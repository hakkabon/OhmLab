* Circuit IR v1 differential fixture: RC low-pass
V1 in 0 DC 0 AC 1
R1 in out 1k
C1 out 0 100n
.end
